ADE simulation setup
Run mode: Single Run, Sweeps and Corners
Tests:
  Gain_Boosted_Cascode:Gain_Boosted_OTA_behavior:1: Gain_Boosted_Cascode/Gain_Boosted_OTA_behavior/schematic, simulator spectre
Global variables:
  AV_N = 100
  AV_P = 100
  L_CASCN = 120n
  L_CASCP = 80n
  L_INPUT = 130n
  L_SOURCEN = 500n
  L_SOURCEP = 600n
  VBN = 350m
  VBP = 734.44m
  VCASCN = 900m
  VCASCP = 350m
  VINCM = 500m
  VOCM = 600m
  W_CASCN = 500u
  W_CASCP = 800u
  W_INPUT = 3m
  W_SOURCEP = 2.32m
  WN_SOURCE = 7.247m
  VDD = 1.2
  cgg2 = 1f
