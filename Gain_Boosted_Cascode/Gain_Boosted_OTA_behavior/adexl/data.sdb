ADE simulation setup
Run mode: Single Run, Sweeps and Corners
Tests:
  Gain_Boosted_Cascode:Gain_Boosted_OTA_behavior:1 (off): Gain_Boosted_Cascode/Gain_Boosted_OTA_behavior/schematic, simulator spectre
  Gain_Boosted_Cascode:Gain_Boosted_Cascode_Actual:1: Gain_Boosted_Cascode/Gain_Boosted_Cascode_Actual/schematic, simulator spectre
Global variables:
  AV_N = 100
  AV_P = 100
  L_CASCN = 120n
  L_CASCP = 120n
  L_INPUT = 160n
  L_SOURCEN = 500n
  L_SOURCEP = 600n
  VBN = 350m
  VBP = 732.3347m
  VCASCN = 900m
  VCASCP = 350m
  VINCM = 500m
  VOCM = 600m
  W_CASCN = 500u*0.35
  W_CASCP = 500u*0.35
  W_INPUT = 4m
  W_SOURCEP = 2.32m*0.4
  WN_SOURCE = 7.247m*0.4
  VDD = 1.2
  cgg2 = 1f
  AUX_NMOS_L_BUF_IN = 100n
  AUX_NMOS_L_BUF_SOURCE = 1u
  AUX_NMOS_L_IN = 2.57u
  AUX_NMOS_L_LOAD = 3.77u
  AUX_NMOS_L_TAIL = 1u
  AUX_NMOS_W_BUF_IN = 3.15u
  AUX_NMOS_W_BUF_SOURCE = 1.975u
  AUX_NMOS_W_IN = 34.35u
  AUX_NMOS_W_LOAD = 6.96u
  AUX_NMOS_W_TAIL = 48u
  AUX_PMOS_L_IN = 2.2u
  AUX_PMOS_L_TAIL = 130n
  AUX_PMOS_LIN_BUF = 100n
  AUX_PMOS_LS_BUF = 1u
  AUX_PMOS_LSOURCE = 6u
  AUX_PMOS_W_IN = 100u
  AUX_PMOS_W_TAIL = 44.5u
  AUX_PMOS_WIN_BUF = 675n*1.5
  AUX_PMOS_WS_BUF = 650n*1.5
  AUX_PMOS_WSOURCE = 5u
  AUXN_VBN = 300m
  AUXN_VBP = 600m
  AUXN_VBUF = 0.7
  AUXN_VOCM = 600m
  AUXP_VBN = 520m
  AUXP_VBP = 900m
  AUXP_VBUF = 500m
  AUXP_VOCM = 750m
Corners:
  model folders: /home/cadence/tsmc65nm/models/spectre
  C0: temperature=-40, 27, 125; VDD=1.08,1.2,1.32; cor_std_mos.scs[ff ss tt fs sf]
