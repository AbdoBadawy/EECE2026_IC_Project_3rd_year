ADE simulation setup
Run mode: Single Run, Sweeps and Corners
Tests:
  Gain_Boosted_Cascode:test_bench:1: Gain_Boosted_Cascode/test_bench/schematic, simulator spectre
Global variables:
  LN = 200n
  LP = 60n
  MN = 1u/60n
  MP = 1u/60n
  VDS = 0.2
  VGS = 0.5
  VSB = 0
