ADE simulation setup
Run mode: Single Run, Sweeps and Corners
Tests:
  Gain_Boosted_Cascode:test_bench:1: Gain_Boosted_Cascode/test_bench/schematic, simulator spectre
    Outputs: cgg/id_N; gds/id_N; css/id_N; cdd/id_N
Global variables:
  LN = 100n
  LP = 600n
  MN = 1u/60n
  MP = 1u/60n
  VDS = 0.15
  VGS = 450m
  VSB = 0
