ADE simulation setup
Run mode: Single Run, Sweeps and Corners
Tests:
  Gain_Boosted_Cascode:pmis_5OTA_Optimized:1: Gain_Boosted_Cascode/pmis_5OTA_Optimized/schematic, simulator spectre
Device parameters:
  Gain_Boosted_Cascode/pmis_5OTA_Optimized/schematic/M0.l = 20u
  Gain_Boosted_Cascode/pmis_5OTA_Optimized/schematic/M0.w = 334.4u
  Gain_Boosted_Cascode/pmis_5OTA_Optimized/schematic/M1.l = 1.98u
  Gain_Boosted_Cascode/pmis_5OTA_Optimized/schematic/M1.w = 8.035u
  Gain_Boosted_Cascode/pmis_5OTA_Optimized/schematic/M5.l = 3.38u
  Gain_Boosted_Cascode/pmis_5OTA_Optimized/schematic/M5.w = 4.66u
  Gain_Boosted_Cascode/pmis_5OTA_Optimized/schematic/V12.vdc = 1.505
  Gain_Boosted_Cascode/pmis_5OTA_Optimized/schematic/V11.vdc = 1.17
