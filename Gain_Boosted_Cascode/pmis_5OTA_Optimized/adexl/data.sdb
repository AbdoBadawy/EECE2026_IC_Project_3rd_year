ADE simulation setup
Run mode: Single Run, Sweeps and Corners
Tests:
  Gain_Boosted_Cascode:pmis_5OTA_Optimized:1: Gain_Boosted_Cascode/pmis_5OTA_Optimized/schematic, simulator spectre
Global variables:
  W = 5u
  LP = 2.2u
  LN = 6u
  W_SOURCE = 44.5u
  VB_BUF = 0.5
  WIN_BUF = 675n*1.5
  WS_BUF = 650n*1.5
  LIN_BUF = 100n
  LS_BUF = 1u
  CL = 10p
Device parameters (all switched off):
  Gain_Boosted_Cascode/pmis_5OTA_Optimized/schematic/M0.l = 20u
  Gain_Boosted_Cascode/pmis_5OTA_Optimized/schematic/M0.w = 334.4u
  Gain_Boosted_Cascode/pmis_5OTA_Optimized/schematic/M1.l = 1.98u
  Gain_Boosted_Cascode/pmis_5OTA_Optimized/schematic/M1.w = 8.035u
  Gain_Boosted_Cascode/pmis_5OTA_Optimized/schematic/M5.l = 3.38u
  Gain_Boosted_Cascode/pmis_5OTA_Optimized/schematic/M5.w = 4.66u
  Gain_Boosted_Cascode/pmis_5OTA_Optimized/schematic/V12.vdc = 1.505
  Gain_Boosted_Cascode/pmis_5OTA_Optimized/schematic/V11.vdc = 1.17
