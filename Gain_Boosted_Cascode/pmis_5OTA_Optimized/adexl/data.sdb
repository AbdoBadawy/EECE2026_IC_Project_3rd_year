ADE simulation setup
Run mode: Local Optimization
Tests:
  Gain_Boosted_Cascode:pmis_5OTA_Optimized:1: Gain_Boosted_Cascode/pmis_5OTA_Optimized/schematic, simulator spectre
    Outputs: BW [Hz]; GAIN [dB]
Device parameters:
  Gain_Boosted_Cascode/pmis_5OTA_Optimized/schematic/M2.l = 100n:150n:1.5u
  Gain_Boosted_Cascode/pmis_5OTA_Optimized/schematic/M2.w = 200n:150n:2u
  Gain_Boosted_Cascode/pmis_5OTA_Optimized/schematic/M2.m = 1 2 4 8
  Gain_Boosted_Cascode/pmis_5OTA_Optimized/schematic/M1.l = M2/l@Gain_Boosted_Cascode/pmis_5OTA_Optimized/schematic
  Gain_Boosted_Cascode/pmis_5OTA_Optimized/schematic/M1.w = M2/w@Gain_Boosted_Cascode/pmis_5OTA_Optimized/schematic
  Gain_Boosted_Cascode/pmis_5OTA_Optimized/schematic/M1.m = M2/m@Gain_Boosted_Cascode/pmis_5OTA_Optimized/schematic
  Gain_Boosted_Cascode/pmis_5OTA_Optimized/schematic/M5.l = 100n:150n:1.5u
  Gain_Boosted_Cascode/pmis_5OTA_Optimized/schematic/M5.w = 200n:150n:2u
  Gain_Boosted_Cascode/pmis_5OTA_Optimized/schematic/M5.m = M4/m@Gain_Boosted_Cascode/pmis_5OTA_Optimized/schematic
  Gain_Boosted_Cascode/pmis_5OTA_Optimized/schematic/M4.l = M5/l@Gain_Boosted_Cascode/pmis_5OTA_Optimized/schematic
  Gain_Boosted_Cascode/pmis_5OTA_Optimized/schematic/M4.w = M5/w@Gain_Boosted_Cascode/pmis_5OTA_Optimized/schematic
  Gain_Boosted_Cascode/pmis_5OTA_Optimized/schematic/M4.m = 1 2 4 8
  Gain_Boosted_Cascode/pmis_5OTA_Optimized/schematic/V12.vdc = 100m:10m:1.2
  Gain_Boosted_Cascode/pmis_5OTA_Optimized/schematic/V11.vdc = 100m:10m:1.2
  Gain_Boosted_Cascode/pmis_5OTA_Optimized/schematic/M0.l = 100n:150n:1.5u
  Gain_Boosted_Cascode/pmis_5OTA_Optimized/schematic/M0.m = 1 2 4 8
  Gain_Boosted_Cascode/pmis_5OTA_Optimized/schematic/M0.w = 200n:150n:2u
Specs:
  Gain_Boosted_Cascode:pmis_5OTA_Optimized:1 / OP("/M0" "region"): target 2, tolerance 1%, weight 100
  Gain_Boosted_Cascode:pmis_5OTA_Optimized:1 / OP("/M1" "region"): target 2, tolerance 1%, weight 100
  Gain_Boosted_Cascode:pmis_5OTA_Optimized:1 / OP("/M4" "region"): target 2, tolerance 1%, weight 100
  Gain_Boosted_Cascode:pmis_5OTA_Optimized:1 / OP("/M2" "region"): target 2, tolerance 1%, weight 100
  Gain_Boosted_Cascode:pmis_5OTA_Optimized:1 / OP("/M5" "region"): target 2, tolerance 1%, weight 100
  Gain_Boosted_Cascode:pmis_5OTA_Optimized:1 / GAIN: > 100, weight 130
  Gain_Boosted_Cascode:pmis_5OTA_Optimized:1 / BW: > 1M, weight 10
Local Optimization options: effort=brentPowell, lazy=1, tillsatisfied=1, startingstateorpoint=Reference Point, startingstatename=NONE
