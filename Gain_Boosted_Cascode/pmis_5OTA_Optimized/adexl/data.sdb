ADE simulation setup
Run mode: Global Optimization
Tests:
  Gain_Boosted_Cascode:pmis_5OTA_Optimized:1: Gain_Boosted_Cascode/pmis_5OTA_Optimized/schematic, simulator spectre
    Outputs: BW [Hz]; GAIN [dB]
Device parameters:
  Gain_Boosted_Cascode/pmis_5OTA_Optimized/schematic/M2.l = 600n:150n:2u
  Gain_Boosted_Cascode/pmis_5OTA_Optimized/schematic/M2.w = 70u:5u:150u
  Gain_Boosted_Cascode/pmis_5OTA_Optimized/schematic/M2.m = 3:1:15
  Gain_Boosted_Cascode/pmis_5OTA_Optimized/schematic/M1.l = M2/l@Gain_Boosted_Cascode/pmis_5OTA_Optimized/schematic
  Gain_Boosted_Cascode/pmis_5OTA_Optimized/schematic/M1.w = M2/w@Gain_Boosted_Cascode/pmis_5OTA_Optimized/schematic
  Gain_Boosted_Cascode/pmis_5OTA_Optimized/schematic/M1.m = M2/m@Gain_Boosted_Cascode/pmis_5OTA_Optimized/schematic
  Gain_Boosted_Cascode/pmis_5OTA_Optimized/schematic/M5.l = 1u:150n:3u
  Gain_Boosted_Cascode/pmis_5OTA_Optimized/schematic/M5.w = 18u:5u:150u
  Gain_Boosted_Cascode/pmis_5OTA_Optimized/schematic/M5.m = M4/m@Gain_Boosted_Cascode/pmis_5OTA_Optimized/schematic
  Gain_Boosted_Cascode/pmis_5OTA_Optimized/schematic/M4.l = M5/l@Gain_Boosted_Cascode/pmis_5OTA_Optimized/schematic
  Gain_Boosted_Cascode/pmis_5OTA_Optimized/schematic/M4.w = M5/w@Gain_Boosted_Cascode/pmis_5OTA_Optimized/schematic
  Gain_Boosted_Cascode/pmis_5OTA_Optimized/schematic/M4.m = 7:1:20
  Gain_Boosted_Cascode/pmis_5OTA_Optimized/schematic/V12.vdc = 0.6:10m:1.2
  Gain_Boosted_Cascode/pmis_5OTA_Optimized/schematic/V11.vdc = 300m:10m:0.7
  Gain_Boosted_Cascode/pmis_5OTA_Optimized/schematic/M0.l = 1u:150n:5u
  Gain_Boosted_Cascode/pmis_5OTA_Optimized/schematic/M0.m = 1:1:15
  Gain_Boosted_Cascode/pmis_5OTA_Optimized/schematic/M0.w = 40u:5u:150u
Specs:
  Gain_Boosted_Cascode:pmis_5OTA_Optimized:1 / OP("/M0" "region"): target 2, tolerance 1%, weight 100
  Gain_Boosted_Cascode:pmis_5OTA_Optimized:1 / OP("/M1" "region"): target 2, tolerance 1%, weight 100
  Gain_Boosted_Cascode:pmis_5OTA_Optimized:1 / OP("/M4" "region"): target 2, tolerance 1%, weight 100
  Gain_Boosted_Cascode:pmis_5OTA_Optimized:1 / OP("/M2" "region"): target 2, tolerance 1%, weight 100
  Gain_Boosted_Cascode:pmis_5OTA_Optimized:1 / OP("/M5" "region"): target 2, tolerance 1%, weight 100
  Gain_Boosted_Cascode:pmis_5OTA_Optimized:1 / GAIN: max 40, weight 80
  Gain_Boosted_Cascode:pmis_5OTA_Optimized:1 / BW: > 1.72M, weight 50
Global Optimization options: referencepoint=0, startingstateorpoint=Reference Point, startingstatename=NONE, lazy=1, tillsatisfied=1
