ADE simulation setup
Run mode: Single Run, Sweeps and Corners
Tests:
  Gain_Boosted_Cascode:Auxilary_Amp_PMOS_test:1: Gain_Boosted_Cascode/Auxilary_Amp_PMOS_test/schematic, simulator spectre
Global variables:
  AUX_PMOS_L_IN = 3u
  AUX_PMOS_L_TAIL = 130n
  AUX_PMOS_LIN_BUF = 100n
  AUX_PMOS_LS_BUF = 1u
  AUX_PMOS_LSOURCE = 6u
  AUX_PMOS_W_IN = 100u*0.5*1.5
  AUX_PMOS_W_TAIL = 44.5u*0.5
  AUX_PMOS_WIN_BUF = 675n*1.5
  AUX_PMOS_WS_BUF = 650n*1.5
  AUX_PMOS_WSOURCE = 5u*0.5
  VB_BUF = 0.5
  AUX_NMOS_L_BUF_IN = 100n
  AUX_NMOS_L_BUF_SOURCE = 1u
  AUX_NMOS_L_IN = 2.57u
  AUX_NMOS_L_LOAD = 3.77u
  AUX_NMOS_L_TAIL = 1u
  AUX_NMOS_W_BUF_IN = 3.15u
  AUX_NMOS_W_BUF_SOURCE = 1.975u
  AUX_NMOS_W_IN = 34.35u
  AUX_NMOS_W_LOAD = 6.96u
  AUX_NMOS_W_TAIL = 48u
  VBN = 520m
  VBP = 900m
  VICM = 800m
  VOCM = 750m
