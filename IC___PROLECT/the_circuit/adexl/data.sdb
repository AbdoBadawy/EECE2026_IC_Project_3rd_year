ADE simulation setup
Run mode: Single Run, Sweeps and Corners
Tests:
  IC___PROLECT:the_circuit:1: IC___PROLECT/the_circuit/schematic, simulator spectre
  IC___PROLECT:the_circuit:2 (off): IC___PROLECT/the_circuit/schematic, simulator spectre
Global variables:
  C3 = 100p
  C4 = 10n
  C6 = 100p
  cop = 10p
  Gop = 10000
  R1 = 10k
  R2 = 10k
  R3 = 480
  R5 = 500
  R6 = 157.6
  Rop = 15.915k
  vcc = 12
  R4 = 5k
